// Design: porting_65nm/LDO_PMOS
simulator lang=spectre
global 0 vdd!
parameters VDD=1.2 VREF=0.6 COUT=1u IB=20u IL=1m R1=800k R2=400k
include "/home/centos/tsmc65nm/models/spectre/crn65gplus_2d5_lk_v1d0.scs" section=tt

// porting_65nm/5TOTA/schematic
subckt porting_65nm_5TOTA_schematic AGND AVDD IB VINN VINP VOUT
    M5 (IB IB AGND AGND) nch l=1.5u w=15.0u m=1 nf=1
    M2 (VP IB AGND AGND) nch l=1.5u w=15.0u m=1 nf=1
    M1 (VOUT VINN VP AGND) nch l=1.7u w=14.0u m=1 nf=1
    M0 (VF VINP VP AGND) nch l=1.7u w=14.0u m=1 nf=1
    M4 (VF VF AVDD AVDD) pch l=1u w=25.0u m=1 nf=1
    M3 (VOUT VF AVDD AVDD) pch l=1u w=25.0u m=1 nf=1
ends porting_65nm_5TOTA_schematic

// porting_65nm/LDO_PMOS/schematic
V3 (vdd! 0) vsource dc=VDD type=dc
V2 (VREF 0) vsource dc=VREF type=dc
I11 (VOUT 0) isource dc=IL type=dc
I0 (vdd! net6) isource dc=IB type=dc
I12 (0 vdd! net6 VREF VF VC) porting_65nm_5TOTA_schematic
M0 (VOUT VC vdd! vdd!) pch l=100n w=16.0u m=20 nf=8
R1 (VF 0) resistor r=R1
R0 (VOUT VF) resistor r=R2
C0 (VOUT 0) capacitor c=COUT
simulatorOptions options temp=27
dcOp dc
saveOptions options currents=all subcktprobelvl=5 saveahdlvars=all
