// Design: porting_65nm/CP_TB
simulator lang=spectre
global 0 vdd!
parameters ISS=40u Period=800n VDD=1.2 VL=-VDD VH=VDD PW=0.5*Period tr=PW/10 tf=PW/10
include "/home/centos/path/to/example/model.scs" section=tt

// porting_65nm/WCM/schematic
subckt WCM AGND AVDD Idown Iup Vb
    M1 (Iup Vb AVDD AVDD) pch l=2u w=3u m=2 nf=1
    M0 (VM Vb AVDD AVDD) pch l=2u w=3u m=2 nf=1
    M7 (net016 VM AGND AGND) nch l=2u w=3u m=2 nf=1
    M6 (Idown Vx net016 AGND) nch l=2u w=3u m=2 nf=1
    M5 (net010 VM AGND AGND) nch l=2u w=3u m=2 nf=1
    M4 (VM Vx net010 AGND) nch l=2u w=3u m=2 nf=1
    M3 (Vx Vx AGND AGND) nch l=2u w=750.0n m=2 nf=1
    M2 (AVDD AVDD Vx AGND) nch l=2u w=3u m=2 nf=1
ends WCM

// porting_65nm/Diff_pair/schematic
subckt Diff_pair AGND AVDD VL VR Vb
    M3 (net9 net9 AVDD AVDD) pch l=2u w=3u m=2 nf=1
    M2 (Vb Vb AVDD AVDD) pch l=2u w=3u m=2 nf=1
    M1 (Vb net9 AVDD AVDD) pch l=2u w=3u m=2 nf=1
    M0 (net9 Vb AVDD AVDD) pch l=2u w=3u m=2 nf=1
    M5 (net9 VR net14 AGND) nch l=600n w=3u m=2 nf=1
    M4 (Vb VL net14 AGND) nch l=600n w=3u m=2 nf=1
    I0 (net14 AGND) isource dc=ISS type=dc
ends Diff_pair

// porting_65nm/CP/schematic
subckt CP AGND AVDD Down\+ Down\- I\+ I\- Up\+ Up\-
    I1 (AGND AVDD I\- I\+ net6) WCM
    I0 (AGND AVDD I\+ I\- net9) WCM
    I3 (AGND AVDD Up\+ Up\- net6) Diff_pair
    I2 (AGND AVDD Down\+ Down\- net9) Diff_pair
ends CP

// analogLib/ideal_balun/schematic
subckt ideal_balun d c p n
    K0 (d 0 p c) transformer n1=2
    K1 (d 0 c n) transformer n1=2
ends ideal_balun

// porting_65nm/CP_TB/schematic
I0 (0 vdd! UP\- UP\+ VOUT\+ VOUT\- UP\+ UP\-) CP
I3 (net06 net05 UP\+ UP\-) ideal_balun
V3 (net06 0) vsource dc=0 type=dc
V1 (net05 0) vsource dc=VDD/2 type=dc
V0 (vdd! 0) vsource dc=VDD type=dc
C1 (VOUT\+ 0) capacitor c=10p ic=600m
C0 (VOUT\- 0) capacitor c=10p ic=600m
nodeset VOUT\-=0.6 VOUT\+=0.6
ic VOUT\-=0.6 VOUT\+=0.6
simulatorOptions options temp=27
dcOp dc
saveOptions options currents=all subcktprobelvl=5 saveahdlvars=all
